`timescale 10ps/1ps
`include "constants.vams"
`include "disciplines.vams"

module comp_v2 ( outn, outp, CLK, VDD, VSS, in1, in2 );
    output outn;
    inout  VDD;
    inout  CLK;
    input  in2;
    input  in1;
    inout  VSS;
    output outp;

    logic CLK;
    logic outn, outp;
    electrical VDD, VSS, in1, in2;
    reg outp, outn;

    always @(posedge CLK)
    begin
        #5
        outn = 0;
        outp = 0;
    end
    always @(negedge CLK)
    begin
        if (V(in1) > V(in2))
        begin
            #57
            outn = 1;
            outp = 0;
        end
        else
        begin
            #57
            outn = 0;
            outp = 1;
        end
    end
endmodule
